simulator( 'spectre )
design(	 "/tmp/david/cadence/simulation/cmos_inv_tb/spectre/schematic/netlist/netlist")
resultsDir( "/tmp/david/cadence/simulation/cmos_inv_tb/spectre/schematic" )
modelFile(
    '("/usr/local/cadence/ncsu-cdk-1.6.0.beta/models/spectre/standalone/ami06N.m" "")
    '("/usr/local/cadence/ncsu-cdk-1.6.0.beta/models/spectre/standalone/ami06P.m" "")
)
analysis('tran ?stop "200n"  )
temp( 27 )
run()
selectResult( 'tran )
plot(getData("/Vout") getData("/net4") )
