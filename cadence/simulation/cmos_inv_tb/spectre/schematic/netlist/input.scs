// Generated for: spectre
// Generated on: Oct 26 19:35:20 2013
// Design library name: 0_Tutorial
// Design cell name: cmos_inv_tb
// Design view name: schematic
simulator lang=spectre
global 0 vdd!
include "/usr/local/cadence/ncsu-cdk-1.6.0.beta/models/spectre/standalone/ami06N.m"
include "/usr/local/cadence/ncsu-cdk-1.6.0.beta/models/spectre/standalone/ami06P.m"

// Library name: 0_Tutorial
// Cell name: cmos_inv
// View name: extracted
subckt cmos_inv Vin Vout
    \+1 (vdd! Vin Vout vdd!) tsmc18dP w=4.5e-07 l=1.8e-07 as=2.2275e-13 \
        ad=2.2275e-13 ps=1.44e-06 pd=1.44e-06 m=1 region=sat
    \+6 (Vin 0) capacitor c=5.65704e-17 m=1
    \+5 (Vin 0) capacitor c=6.1371e-17 m=1
    \+4 (vdd! 0) capacitor c=1.26545e-16 m=1
    \+3 (Vout 0) capacitor c=1.22225e-16 m=1
    \+2 (Vout vdd!) capacitor c=3.47472e-17 m=1
    \+0 (0 Vin Vout 0) tsmc18dN w=4.5e-07 l=1.8e-07 as=2.2275e-13 \
        ad=2.2275e-13 ps=1.44e-06 pd=1.44e-06 m=1 region=sat
ends cmos_inv
// End of subcircuit definition.

// Library name: 0_Tutorial
// Cell name: cmos_inv_tb
// View name: schematic
Inv_0 (net4 Vout) cmos_inv
V0 (vdd! 0) vsource type=dc dc=1.8
C0 (Vout 0) capacitor c=10f m=1
V1 (net4 0) vsource type=pulse val0=0 val1=1.8 period=80n delay=0 \
        rise=100p fall=100p width=40n
simulatorOptions options reltol=1e-3 vabstol=1e-6 iabstol=1e-12 temp=27 \
    tnom=27 scalem=1.0 scale=1.0 gmin=1e-12 rforce=1 maxnotes=5 maxwarns=5 \
    digits=5 cols=80 pivrel=1e-3 sensfile="../psf/sens.output" \
    checklimitdest=psf
tran tran stop=200n write="spectre.ic" writefinal="spectre.fc" \
    annotate=status maxiters=5
finalTimeOP info what=oppoint where=rawfile
modelParameter info what=models where=rawfile
element info what=inst where=rawfile
outputParameter info what=output where=rawfile
designParamVals info what=parameters where=rawfile
primitives info what=primitives where=rawfile
subckts info what=subckts  where=rawfile
saveOptions options save=allpub
