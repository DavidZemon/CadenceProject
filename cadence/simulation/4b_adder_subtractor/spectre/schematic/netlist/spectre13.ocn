simulator( 'spectre )
design(	 "/tmp/kancy/cadence/simulation/4b_adder_subtractor/spectre/schematic/netlist/netlist")
resultsDir( "/tmp/kancy/cadence/simulation/4b_adder_subtractor/spectre/schematic" )
modelFile(
    '("/usr/local/cadence/ncsu-cdk-1.6.0.beta/models/spectre/standalone/tsmc18d.scs" "")
)
analysis('tran ?stop "20m"  )
temp( 27 )
run()
selectResult( 'tran )
plot(getData("/Ci") getData("/op") getData("/A<3>") getData("/A<2>") getData("/A<1>") getData("/A<0>") getData("/B<3>") getData("/B<2>") getData("/B<1>") getData("/B<0>") getData("/S<3>") getData("/S<2>") getData("/S<1>") getData("/S<0>") getData("/Co") )
